//Verilog-AMS HDL for "PLL_project", "VCO_AMS" "verilogams"

`include "constants.vams"
`include "disciplines.vams"

module VCO_AMS ( );

endmodule
